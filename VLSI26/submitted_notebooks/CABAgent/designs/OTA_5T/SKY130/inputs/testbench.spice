** testbench for five_transistor_ota
x1 VDD VSS VIN VIP VOUT IB five_transistor_ota
VDD VDD VSS VDD
VSS VSS GND 0
V3 VI VSS dc 0 ac 1 sin 0 vi fi
E1 VIP net1 VI VSS 0.5
E2 VIN net1 VSS VI 0.5
V5 net1 VSS VCM
C1 VOUT VSS 10p m=1
I0 VDD IB IB

.param mc_mm_switch=0
.param mc_pr_switch=0
.include /usr/local/share/pdk/sky130A/libs.tech/ngspice/corners/tt.spice
.include /usr/local/share/pdk/sky130A/libs.tech/ngspice/r+c/res_typical__cap_typical.spice
.include /usr/local/share/pdk/sky130A/libs.tech/ngspice/r+c/res_typical__cap_typical__lin.spice
.include /usr/local/share/pdk/sky130A/libs.tech/ngspice/corners/tt/specialized_cells.spice

.include /home/Spec2Layout/designs/OTA_5T/SKY130/runs/ngspice/param.spice

.option reltol=1e-3 vabstol=1e-6 iabstol=1e-12 trtol=7

.control
  run
  save all

  op

  ac dec 10 1 1e9
  let gain = dB(v(VOUT)/v(VI))
  let phase = 180/pi*cph(v(VOUT)/v(VI))
  wrdata gain.txt gain
  wrdata phase.txt phase

  meas ac G_max MAX gain
  let G_3dB=G_max-3
  meas ac f_3dB WHEN gain=G_3dB
  meas ac f_gc WHEN gain=0
  meas ac phase_at_gc FIND phase AT=f_gc
  let PM=phase_at_gc+180
  print PM

  noise V(VOUT) V3 dec 100 1 1e9
  setplot noise1
  wrdata inoise.txt inoise_spectrum

  tran 1n 20u
  wrdata transient_in.txt v(VI)
  wrdata transient_out.txt v(VOUT)

  fourier 100k v(VOUT)
  let idx = 2
  let sum_mag_square = 0
  while idx < 10
    let mag = fourier11[1][idx]
    let sum_mag_square = sum_mag_square + mag * mag
    let idx = idx + 1
  end
  let root_sum_mag_square = sqrt(sum_mag_square)
  let thd = root_sum_mag_square / fourier11[1][1] * 100
  print thd
  echo THD_percent $&thd > THD.txt

.endc

*.subckt five_transistor_ota VDD VSS VIN VIP VOUT IB
*.ends

.GLOBAL GND
.end
